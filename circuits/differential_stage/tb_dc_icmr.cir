* ==============================================================================
* TESTBENCH: tb_dc_icmr.cir
* CIRCUIT: CMOS Differential Input Stage
* PURPOSE: Input Common-Mode Range (ICMR) DC Analysis (0 V to 0.8 V)
* ==============================================================================

.include models/cmos_models.inc

.param VDD_val = 0.80

* Power Supply
VDD VDD 0 DC {VDD_val}

* CMOS Bias Network
Rbias VDD   VBIAS 173.5k
M6    VBIAS VBIAS 0 0 NMOS_LV L=1.0u W=2.7u

* Tail Current Sink
M5    TAIL  VBIAS 0 0 NMOS_LV L=1.0u W=2.7u

* NMOS Differential Input Pair
M1    N_D1  IN_CM TAIL 0 NMOS_LV L=1.0u W=4.0u
M2    OUT   IN_CM TAIL 0 NMOS_LV L=1.0u W=4.0u

* PMOS Active Mirror Load
M3    N_D1  N_D1  VDD  VDD PMOS_LV L=1.0u W=6.4u
M4    OUT   N_D1  VDD  VDD PMOS_LV L=1.0u W=6.4u

* Output Load Capacitance
CL    OUT   0     1p

* Common-Mode Source swept across full rail
Vicm  IN_CM 0     DC 0.60

* Analysis Directive: Sweep Vicm from 0 V to 0.8 V in 1 mV steps
.dc Vicm 0 0.80 0.001

* Measurements:
* Tail current maintains >= 90% of nominal (1.8 uA)
.meas dc Itail_nom  FIND Id(M5) AT=0.60
.meas dc Vds_M5     FIND V(TAIL) AT=0.60
.meas dc Vout_cm    FIND V(OUT) AT=0.60

.end
