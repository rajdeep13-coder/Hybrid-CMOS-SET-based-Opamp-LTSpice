* ==============================================================================
* TESTBENCH: tb_ac_diff.cir
* CIRCUIT: CMOS Differential Input Stage
* PURPOSE: Differential AC Small-Signal Frequency Response (Gain, Bandwidth, GBW)
* ==============================================================================

.include models/cmos_models.inc

.param VDD_val  = 0.80
.param VICM_val = 0.60

* Power Supply
VDD VDD 0 DC {VDD_val}

* CMOS Bias Network
Rbias VDD   VBIAS 173.5k
M6    VBIAS VBIAS 0 0 NMOS_LV L=1.0u W=2.7u

* Tail Current Sink
M5    TAIL  VBIAS 0 0 NMOS_LV L=1.0u W=2.7u

* NMOS Differential Input Pair
M1    N_D1  IN_P  TAIL 0 NMOS_LV L=1.0u W=4.0u
M2    OUT   IN_N  TAIL 0 NMOS_LV L=1.0u W=4.0u

* PMOS Active Mirror Load
M3    N_D1  N_D1  VDD  VDD PMOS_LV L=1.0u W=6.4u
M4    OUT   N_D1  VDD  VDD PMOS_LV L=1.0u W=6.4u

* Output Load Capacitance
CL    OUT   0     1p

* Differential AC Input Sources
VIP   IN_P  0     DC {VICM_val} AC 0.5 0
VIN   IN_N  0     DC {VICM_val} AC 0.5 180

* Analysis Directive: Decadal sweep from 1 Hz to 1 GHz
.ac dec 20 1 1G

* Measurements
.meas ac Ad_0dB   FIND mag(V(OUT)) AT 1
.meas ac Ad_dB    FIND 20*log10(mag(V(OUT))) AT 1
.meas ac f_3dB    WHEN mag(V(OUT))=Ad_0dB/sqrt(2)
.meas ac GBW      WHEN mag(V(OUT))=1
.meas ac Phase_lf FIND ph(V(OUT)) AT 1

.end
