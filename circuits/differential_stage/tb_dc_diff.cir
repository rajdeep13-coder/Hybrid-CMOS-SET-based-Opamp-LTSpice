* ==============================================================================
* TESTBENCH: tb_dc_diff.cir
* CIRCUIT: CMOS Differential Input Stage
* PURPOSE: Differential Input DC Transfer Characteristic & Large-Signal Gain
* ==============================================================================

.include models/cmos_models.inc

.param VDD_val  = 0.80
.param VICM_val = 0.60

* Power Supply
VDD VDD 0 DC {VDD_val}

* CMOS Bias Network
Rbias VDD   VBIAS 173.5k
M6    VBIAS VBIAS 0 0 NMOS_LV L=1.0u W=2.7u

* Tail Current Sink
M5    TAIL  VBIAS 0 0 NMOS_LV L=1.0u W=2.7u

* NMOS Differential Input Pair
M1    N_D1  IN_P  TAIL 0 NMOS_LV L=1.0u W=4.0u
M2    OUT   IN_N  TAIL 0 NMOS_LV L=1.0u W=4.0u

* PMOS Active Mirror Load
M3    N_D1  N_D1  VDD  VDD PMOS_LV L=1.0u W=6.4u
M4    OUT   N_D1  VDD  VDD PMOS_LV L=1.0u W=6.4u

* Output Load Capacitance
CL    OUT   0     1p

* Differential Input Generator:
* IN_P = VICM + Vid/2
* IN_N = VICM - Vid/2
Vcm ICM 0 DC {VICM_val}
Vd  Vid 0 DC 0
E1  IN_P ICM Vid 0 0.5
E2  IN_N ICM Vid 0 -0.5

* Analysis Directive: Sweep Vid from -50 mV to +50 mV in 0.1 mV steps
.dc Vd -0.05 0.05 0.0001

* Measurements
.meas dc Vout_zero     FIND V(OUT) AT=0
.meas dc Vout_sat_high MAX V(OUT)
.meas dc Vout_sat_low  MIN V(OUT)
.meas dc Gain_dc_VperV DERIV V(OUT) AT=0
.meas dc Gain_dc_dB    PARAM (20*log10(Gain_dc_VperV))

.end
