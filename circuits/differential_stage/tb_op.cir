* ==============================================================================
* TESTBENCH: tb_op.cir
* CIRCUIT: CMOS Differential Input Stage
* PURPOSE: Operating Point (.op), Branch Currents, Transistor Regions & Power
* ==============================================================================

.include models/cmos_models.inc

.param VDD_val  = 0.80
.param VICM_val = 0.60

* Power Supply
VDD VDD 0 DC {VDD_val}

* CMOS Bias Network
Rbias VDD   VBIAS 173.5k
M6    VBIAS VBIAS 0 0 NMOS_LV L=1.0u W=2.7u

* Tail Current Sink
M5    TAIL  VBIAS 0 0 NMOS_LV L=1.0u W=2.7u

* NMOS Differential Input Pair
M1    N_D1  IN_P  TAIL 0 NMOS_LV L=1.0u W=4.0u
M2    OUT   IN_N  TAIL 0 NMOS_LV L=1.0u W=4.0u

* PMOS Active Mirror Load
M3    N_D1  N_D1  VDD  VDD PMOS_LV L=1.0u W=6.4u
M4    OUT   N_D1  VDD  VDD PMOS_LV L=1.0u W=6.4u

* Output Load Capacitance
CL    OUT   0     1p

* Common-Mode DC Bias
VIP   IN_P  0     DC {VICM_val}
VIN   IN_N  0     DC {VICM_val}

* Analysis Directive
.op

* Measurement Directives
.meas op V_vdd      FIND V(VDD)
.meas op V_vbias    FIND V(VBIAS)
.meas op V_tail     FIND V(TAIL)
.meas op V_d1       FIND V(N_D1)
.meas op V_out      FIND V(OUT)

.meas op I_bias     FIND I(Rbias)
.meas op I_tail     FIND Id(M5)
.meas op I_m1       FIND Id(M1)
.meas op I_m2       FIND Id(M2)
.meas op I_m3       FIND -Id(M3)
.meas op I_m4       FIND -Id(M4)
.meas op I_bal_err  PARAM abs(I_m1 - I_m2)

.meas op Vds_M5     PARAM V_tail
.meas op Vds_M1     PARAM (V_d1 - V_tail)
.meas op Vds_M2     PARAM (V_out - V_tail)
.meas op Vds_M3     PARAM (V_vdd - V_d1)
.meas op Vds_M4     PARAM (V_vdd - V_out)

.meas op P_diss     PARAM (V_vdd * (-I(VDD)))

.end
